Simulation of the super source follower with the EKV 2.6 model by C. Enz

.include ekv018va.par ; model file for EKV2.6
.include size_bias4.par ; Size and bias values
.include ssfol.ac.par ; Parameter for the AC simulation
.include ssfol.net ; Circuit netlist

.control
 op
 save v(1)
 write $inputdir/ssfol.ac.op
 ac dec $&Ndec $&fmin $&fmax
 let AmagdB=vdb(1)
 let Aphdeg=180/PI*vp(1)
 meas ac Adc max AmagdB
 meas ac fp1 when Aphdeg=135
 meas ac fp2 when Aphdeg=45
 meas ac GBW when AmagdB=0
 meas ac PGBW find Aphdeg at=GBW
 set wr_singlescale
 set wr_vecnames
 wrdata $inputdir/ssfol.ac.dat AmagdB Aphdeg
.endc
.end
