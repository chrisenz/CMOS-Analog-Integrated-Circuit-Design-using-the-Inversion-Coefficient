Simulation of the simple voltage follower with the EKV 2.6 model by C. Enz

.include ekv018va.par ; model file for EKV2.6
.include size_bias.par ; Size and bias values
.include svf.ac.par ; Parameter for the AC simulation
.include svf.net ; Circuit netlist

.control
 op
 save v(out)
 write $inputdir/svf.ac.o
 ac dec $&Ndec $&fmin $&fmax
 let AmagdB=vdb(out)
 let Aphdeg=180/PI*vp(out)
 meas ac Adc max AmagdB
 meas ac fc when Aphdeg=-45
 set wr_singlescale
 set wr_vecnames
 wrdata $inputdir/svf.ac.dat AmagdB Aphdeg
.endc
.end
