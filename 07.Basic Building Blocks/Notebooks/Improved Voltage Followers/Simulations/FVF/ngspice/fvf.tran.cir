Simulation of the flipped voltage follower with the EKV 2.6 model by C. Enz

.include ekv018va.par ; model file for EKV2.6
.include size_bias.par ; Size and bias values
.include fvf.tran.par ; Parameter for the TRAN simulation
.include fvf.tran.net ; Circuit netlist

.control
 op
 save v(in) v(out)
 write $inputdir/fvf.tran.op
 tran $&tstep $&tstop $&tstart
 let Vin=v(in)
 let Vout=v(out)
 set wr_singlescale
 set wr_vecnames
 wrdata $inputdir/fvf.tran.dat Vin Vout
.endc
.end
