Simulation of the flipped voltage follower with the EKV 2.6 model by C. Enz

.include ekv018va.par ; model file for EKV2.6
.include size_bias.par ; Size and bias values
.include fvf.ac.par ; Parameter for the AC simulation
.include fvf.net ; Circuit netlist

.control
 op
 save v(out)
 write $inputdir/fvf.ac.op
 ac dec $&Ndec $&fmin $&fmax
 let AmagdB=vdb(out)
 let Aphdeg=180/PI*vp(out)
 meas ac Adc max AmagdB
 set wr_singlescale
 set wr_vecnames
 wrdata $inputdir/fvf.ac.dat AmagdB Aphdeg
.endc
.end
